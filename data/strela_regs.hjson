// Copyright 2026 CEIMM-UPM
// Solderpad Hardware License, Version 2.1, see LICENSE.md for details.
// SPDX-License-Identifier: Apache-2.0 WITH SHL-2.1
// Daniel Vazquez (daniel.vazquez@upm.es)

{
  name: "strela",
  clock_primary: "clk_i",
  bus_interfaces: [
    { protocol: "reg_iface", direction: "device" }
  ],
  regwidth: "32",
  registers: [
    { name:     "CTRL",
      desc:     "STRELA control register",
      resval:   0,
      swaccess: "wo",
      hwaccess: "hrw",
      fields: [
        { bits: "0", name: "START",        desc: "Start" }
        { bits: "1", name: "CLR",          desc: "Clear all IP" }
        { bits: "2", name: "CLR_PARAM",    desc: "Clear parameters (MMIO registers)" }
        { bits: "3", name: "CLR_CONF",     desc: "Clear configuration (CGRA core)" }
        { bits: "4", name: "CLR_PERF_CTR", desc: "Clear performance counters" }
      ]
    }

    {
      name:     "MODE",
      desc:     "STRELA mode register",
      resval:   0,
      swaccess: "wo",
      hwaccess: "hrw",
      fields: [
        { bits: "0", name: "INTR_EN",      desc: "Enable interrupts" }
        { bits: "1", name: "PERF_CTR_EN",  desc: "Enable performance counters" }
      ]
    }

    { name:     "STATUS",
      desc:     "STRELA status register",
      resval:   0,
      swaccess: "ro",
      hwaccess: "hwo",
      fields: [
        { bits: "0", name: "EXEC_DONE", desc: "Execution done" }
        { bits: "1", name: "CONF_DONE", desc: "Configuration done" }
      ]
    }

    // Performance counters

    { name:     "PERF_CTR_TOTAL_CYCLES",
      desc:     "STRELA performance counter: total cycles",
      resval:   0,
      swaccess: "ro",
      hwaccess: "hrw",
      fields: [
        { bits: "31:0", name: "PERF_CTR_TOTAL_CYCLES", desc: "STRELA performance counter: total cycles" }
      ]
    }

    { name:     "PERF_CTR_EXEC_CYCLES",
      desc:     "STRELA performance counter: execution cycles",
      resval:   0,
      swaccess: "ro",
      hwaccess: "hrw",
      fields: [
        { bits: "31:0", name: "PERF_CTR_EXEC_CYCLES", desc: "STRELA performance counter: execution cycles" }
      ]
    }

    { name:     "PERF_CTR_CONF_CYCLES",
      desc:     "STRELA performance counter: configuration cycles",
      resval:   0,
      swaccess: "ro",
      hwaccess: "hrw",
      fields: [
        { bits: "31:0", name: "PERF_CTR_CONF_CYCLES", desc: "STRELA performance counter: configuration cycles" }
      ]
    }

    { name:     "PERF_CTR_STALL_CYCLES",
      desc:     "STRELA performance counter: stall cycles",
      resval:   0,
      swaccess: "ro",
      hwaccess: "hrw",
      fields: [
        { bits: "31:0", name: "PERF_CTR_STALL_CYCLES", desc: "STRELA performance counter: stall cycles" }
      ]
    }

    // Input Memory Nodes

    { name:     "CONF_ADDR",
      desc:     "STRELA configuration address register",
      resval:   0,
      swaccess: "rw",
      hwaccess: "hrw",
      fields: [
        { bits: "31:0", name: "CONF_ADDR", desc: "STRELA configuration address register" }
      ]
    }

    { name:     "ISE_SEW",
      desc:     "STRELA Input Stream Engines selected element width. One 3-bit field per engine, bits [3i+2:3i]; bits 23:12 are reserved for engines 4-7",
      resval:   2925,
      swaccess: "rw",
      hwaccess: "hrw",
      fields: [
        { bits: "2:0", name: "ISE_0_SEW", desc: "Input Stream Engine 0 selected element width (3: 8-bit, 4: 16-bit, 5: 32-bit)", resval: 5 }
        { bits: "5:3", name: "ISE_1_SEW", desc: "Input Stream Engine 1 selected element width (3: 8-bit, 4: 16-bit, 5: 32-bit)", resval: 5 }
        { bits: "8:6", name: "ISE_2_SEW", desc: "Input Stream Engine 2 selected element width (3: 8-bit, 4: 16-bit, 5: 32-bit)", resval: 5 }
        { bits: "11:9", name: "ISE_3_SEW", desc: "Input Stream Engine 3 selected element width (3: 8-bit, 4: 16-bit, 5: 32-bit)", resval: 5 }
      ]
    }

    { name:     "OSE_SEW",
      desc:     "STRELA Output Stream Engines selected element width. One 3-bit field per engine, bits [3i+2:3i]; bits 23:12 are reserved for engines 4-7",
      resval:   2925,
      swaccess: "rw",
      hwaccess: "hrw",
      fields: [
        { bits: "2:0", name: "OSE_0_SEW", desc: "Output Stream Engine 0 selected element width (3: 8-bit, 4: 16-bit, 5: 32-bit)", resval: 5 }
        { bits: "5:3", name: "OSE_1_SEW", desc: "Output Stream Engine 1 selected element width (3: 8-bit, 4: 16-bit, 5: 32-bit)", resval: 5 }
        { bits: "8:6", name: "OSE_2_SEW", desc: "Output Stream Engine 2 selected element width (3: 8-bit, 4: 16-bit, 5: 32-bit)", resval: 5 }
        { bits: "11:9", name: "OSE_3_SEW", desc: "Output Stream Engine 3 selected element width (3: 8-bit, 4: 16-bit, 5: 32-bit)", resval: 5 }
      ]
    }

    // Input Stream Engines

    { name:     "ISE_0_ADDR",
      desc:     "STRELA Input Stream Engine 0 address register",
      resval:   0,
      swaccess: "rw",
      hwaccess: "hrw",
      fields: [
        { bits: "31:0", name: "ISE_0_ADDR", desc: "STRELA Input Stream Engine 0 address register" }
      ]
    }

    { name:     "ISE_0_PARAM",
      desc:     "STRELA Input Stream Engine 0 size and stride register",
      resval:   0,
      swaccess: "rw",
      hwaccess: "hrw",
      fields: [
        { bits: "15:0", name: "ISE_0_SIZE", desc: "STRELA Input Stream Engine 0 size: byte span, stride * count" }
        { bits: "31:16", name: "ISE_0_STRIDE", desc: "STRELA Input Stream Engine 0 stride in bytes" }
      ]
    }

    { name:     "ISE_1_ADDR",
      desc:     "STRELA Input Stream Engine 1 address register",
      resval:   0,
      swaccess: "rw",
      hwaccess: "hrw",
      fields: [
        { bits: "31:0", name: "ISE_1_ADDR", desc: "STRELA Input Stream Engine 1 address register" }
      ]
    }

    { name:     "ISE_1_PARAM",
      desc:     "STRELA Input Stream Engine 1 size and stride register",
      resval:   0,
      swaccess: "rw",
      hwaccess: "hrw",
      fields: [
        { bits: "15:0", name: "ISE_1_SIZE", desc: "STRELA Input Stream Engine 1 size: byte span, stride * count" }
        { bits: "31:16", name: "ISE_1_STRIDE", desc: "STRELA Input Stream Engine 1 stride in bytes" }
      ]
    }

    { name:     "ISE_2_ADDR",
      desc:     "STRELA Input Stream Engine 2 address register",
      resval:   0,
      swaccess: "rw",
      hwaccess: "hrw",
      fields: [
        { bits: "31:0", name: "ISE_2_ADDR", desc: "STRELA Input Stream Engine 2 address register" }
      ]
    }

    { name:     "ISE_2_PARAM",
      desc:     "STRELA Input Stream Engine 2 size and stride register",
      resval:   0,
      swaccess: "rw",
      hwaccess: "hrw",
      fields: [
        { bits: "15:0", name: "ISE_2_SIZE", desc: "STRELA Input Stream Engine 2 size: byte span, stride * count" }
        { bits: "31:16", name: "ISE_2_STRIDE", desc: "STRELA Input Stream Engine 2 stride in bytes" }
      ]
    }

    { name:     "ISE_3_ADDR",
      desc:     "STRELA Input Stream Engine 3 address register",
      resval:   0,
      swaccess: "rw",
      hwaccess: "hrw",
      fields: [
        { bits: "31:0", name: "ISE_3_ADDR", desc: "STRELA Input Stream Engine 3 address register" }
      ]
    }

    { name:     "ISE_3_PARAM",
      desc:     "STRELA Input Stream Engine 3 size and stride register",
      resval:   0,
      swaccess: "rw",
      hwaccess: "hrw",
      fields: [
        { bits: "15:0", name: "ISE_3_SIZE", desc: "STRELA Input Stream Engine 3 size: byte span, stride * count" }
        { bits: "31:16", name: "ISE_3_STRIDE", desc: "STRELA Input Stream Engine 3 stride in bytes" }
      ]
    }

    // Output Stream Engines

    { name:     "OSE_0_ADDR",
      desc:     "STRELA Output Stream Engine 0 address register",
      resval:   0,
      swaccess: "rw",
      hwaccess: "hrw",
      fields: [
        { bits: "31:0", name: "OSE_0_ADDR", desc: "STRELA Output Stream Engine 0 address register" }
      ]
    }

    { name:     "OSE_0_PARAM",
      desc:     "STRELA Output Stream Engine 0 size and stride register",
      resval:   0,
      swaccess: "rw",
      hwaccess: "hrw",
      fields: [
        { bits: "15:0", name: "OSE_0_SIZE", desc: "STRELA Output Stream Engine 0 size: byte span, stride * count" }
        { bits: "31:16", name: "OSE_0_STRIDE", desc: "STRELA Output Stream Engine 0 stride in bytes" }
      ]
    }

    { name:     "OSE_1_ADDR",
      desc:     "STRELA Output Stream Engine 1 address register",
      resval:   0,
      swaccess: "rw",
      hwaccess: "hrw",
      fields: [
        { bits: "31:0", name: "OSE_1_ADDR", desc: "STRELA Output Stream Engine 1 address register" }
      ]
    }

    { name:     "OSE_1_PARAM",
      desc:     "STRELA Output Stream Engine 1 size and stride register",
      resval:   0,
      swaccess: "rw",
      hwaccess: "hrw",
      fields: [
        { bits: "15:0", name: "OSE_1_SIZE", desc: "STRELA Output Stream Engine 1 size: byte span, stride * count" }
        { bits: "31:16", name: "OSE_1_STRIDE", desc: "STRELA Output Stream Engine 1 stride in bytes" }
      ]
    }

    { name:     "OSE_2_ADDR",
      desc:     "STRELA Output Stream Engine 2 address register",
      resval:   0,
      swaccess: "rw",
      hwaccess: "hrw",
      fields: [
        { bits: "31:0", name: "OSE_2_ADDR", desc: "STRELA Output Stream Engine 2 address register" }
      ]
    }

    { name:     "OSE_2_PARAM",
      desc:     "STRELA Output Stream Engine 2 size and stride register",
      resval:   0,
      swaccess: "rw",
      hwaccess: "hrw",
      fields: [
        { bits: "15:0", name: "OSE_2_SIZE", desc: "STRELA Output Stream Engine 2 size: byte span, stride * count" }
        { bits: "31:16", name: "OSE_2_STRIDE", desc: "STRELA Output Stream Engine 2 stride in bytes" }
      ]
    }

    { name:     "OSE_3_ADDR",
      desc:     "STRELA Output Stream Engine 3 address register",
      resval:   0,
      swaccess: "rw",
      hwaccess: "hrw",
      fields: [
        { bits: "31:0", name: "OSE_3_ADDR", desc: "STRELA Output Stream Engine 3 address register" }
      ]
    }

    { name:     "OSE_3_PARAM",
      desc:     "STRELA Output Stream Engine 3 size and stride register",
      resval:   0,
      swaccess: "rw",
      hwaccess: "hrw",
      fields: [
        { bits: "15:0", name: "OSE_3_SIZE", desc: "STRELA Output Stream Engine 3 size: byte span, stride * count" }
        { bits: "31:16", name: "OSE_3_STRIDE", desc: "STRELA Output Stream Engine 3 stride in bytes" }
      ]
    }
  ]
}
